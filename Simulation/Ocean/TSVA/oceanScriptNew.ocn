simulator( 'spectre )
design(	 "/home/julien/Shared/Projects/simulation/TwoStage/spectre/schematic/netlist/netlist")
resultsDir( "/home/julien/Shared/Projects/simulation/TwoStage/spectre/schematic" )
modelFile(
    '("/opt/cadence/installs/ncsu-cdk-1.6.0/models/45n270AModels.sp" "")
)
analysis('ac ?start "10"  ?stop "100G"  )
analysis('dc ?saveOppoint t  )
desVar(	  "C0" 200f	)
desVar(   "C1" 1.5e-13 )
desVar(	  "Vb1" 1.5	)
desVar(	  "Vb2" 1.8	)
desVar(	  "Vb3" 2.7	)
desVar(	  "Vb4" 620m	)
desVar(	  "Vb5" 1	)
desVar(	  "Vbmain" 740m	)
desVar(	  "VDD" 3.3	)
desVar(   "WCS" 5.2e-06 )
desVar(   "WN1" 3.25e-06 )
desVar(   "WNOUT" 4.5e-06 )
desVar(   "WP1" 4.5e-06 )
desVar(   "WPOUT" 2.7000000000000004e-06 )
envOption(
	'analysisOrder  list("dc" "ac")
)
saveOption( 'pwr "all" )
saveOption( 'save "all" )
save( 'v "/Vout+" "/Vout-" "/Vin+" "/Vin-" )
temp( 27 )
run()

VoltageGain = ymax(dB20(((VF("/Vout+") - VF("/Vout-")) / (VF("/Vin+") - VF("/Vin-")))))
Bandwidth = cross(dB20(((VF("/Vout+") - VF("/Vout-")) / (VF("/Vin+") - VF("/Vin-")))) (ymax(dB20(((VF("/Vout+") - VF("/Vout-")) / (VF("/Vin+") - VF("/Vin-"))))) - 3) 1 "falling" nil nil nil)
PowerConsumption = getData(":pwr" ?result "dcOp")

filePtr = outfile("./results.txt" "w")
ocnPrint( ?output filePtr "Simulated performance ..." )
ocnPrint( ?output filePtr ?numberNotation 'scientific ?numSpaces 1 "VoltageGain:" VoltageGain )
ocnPrint( ?output filePtr ?numberNotation 'scientific ?numSpaces 1 "Bandwidth:" Bandwidth )
ocnPrint( ?output filePtr ?numberNotation 'scientific ?numSpaces 1 "PowerConsumption:" PowerConsumption )
close(filePtr)
