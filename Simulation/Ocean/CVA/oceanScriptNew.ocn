simulator( 'spectre )
design(  "/home/julien/Shared/Projects/simulation/Cascode/spectre/schematic/netlist/netlist")
resultsDir( "/home/julien/Shared/Projects/simulation/Cascode/spectre/schematic" )
modelFile(
    '("/opt/cadence/installs/ncsu-cdk-1.6.0/models/45n270AModels.sp" "")
)
analysis('ac ?start "0"  ?stop "10G"  )
analysis('dc ?saveOppoint t  )
desVar(   "Wbias" 6.2e-06 )
desVar(   "Wn2" 8.400000000000001e-06 )
desVar(   "Rd" 600.0 )
desVar(   "Wn1" 1.34e-05 )
envOption(
	'analysisOrder  list("dc" "ac")
)
saveOption( 'pwr "all" )
saveOption( 'save "all" )
save( 'v "/Vout+" "/Vin+" "/Vin-" )
temp( 27 )
run()

VoltageGain = ymax(dB20((VF("/Vout+") / VF("/Vin+"))))
Bandwidth = bandwidth((VF("/Vout+") / VF("/Vin-")) 3 "low")
PowerConsumption = getData(":pwr" ?result "dcOp")

filePtr = outfile("./results.txt" "w")
ocnPrint( ?output filePtr "Simulated performance ..." )
ocnPrint( ?output filePtr ?numberNotation 'scientific ?numSpaces 1 "VoltageGain:" VoltageGain )
ocnPrint( ?output filePtr ?numberNotation 'scientific ?numSpaces 1 "Bandwidth:" Bandwidth )
ocnPrint( ?output filePtr ?numberNotation 'scientific ?numSpaces 1 "PowerConsumption:" PowerConsumption )
close(filePtr)
