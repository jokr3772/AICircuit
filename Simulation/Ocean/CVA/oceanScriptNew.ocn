simulator( 'spectre )
design(  "Simulation/Netlists/CVA/netlist/netlist")
resultsDir( "Simulation/Results/CVA/" )
modelFile(
    '("Simulation/Model/45n270AModels.sp" "")
)
analysis('ac ?start "0"  ?stop "10G"  )
analysis('dc ?saveOppoint t  )
desVar(   "Wbias" 7.367479853332043e-06 )
desVar(   "Wn2" 4.875545799732209e-06 )
desVar(   "Rd" 1433.1996031105518 )
desVar(   "Wn1" 1.1882678136229514e-05 )
envOption(
	'analysisOrder  list("dc" "ac")
)
saveOption( 'pwr "all" )
saveOption( 'save "all" )
save( 'v "/Vout+" "/Vin+" "/Vin-" )
temp( 27 )
run()

VoltageGain = ymax(dB20((VF("/Vout+") / VF("/Vin+"))))
Bandwidth = bandwidth((VF("/Vout+") / VF("/Vin-")) 3 "low")
PowerConsumption = getData(":pwr" ?result "dcOp")

filePtr = outfile("./results.txt" "w")
ocnPrint( ?output filePtr "Simulated performance ..." )
ocnPrint( ?output filePtr ?numberNotation 'scientific ?numSpaces 1 "VoltageGain:" VoltageGain )
ocnPrint( ?output filePtr ?numberNotation 'scientific ?numSpaces 1 "Bandwidth:" Bandwidth )
ocnPrint( ?output filePtr ?numberNotation 'scientific ?numSpaces 1 "PowerConsumption:" PowerConsumption )
close(filePtr)
