simulator( 'spectre )
design(  "/home/julien/Shared/Projects/simulation/LNA_testbench/spectre/schematic/netlist/netlist")
resultsDir( "/home/julien/Shared/Projects/simulation/LNA_testbench/spectre/schematic" )
modelFile(
    '("/opt/cadence/installs/ncsu-cdk-1.6.0/models/45n270AModels.sp" "")
)
analysis('sp ?ports list("/PORT0" "/PORT1")  ?start "1G"  ?stop "10G"
		?donoise "yes"  ?oprobe "/PORT1"  ?iprobe "/PORT0"  )
analysis('dc ?saveOppoint t  )
desVar(	  "Vbmain" 1	)
desVar(	  "Z0" 200	)
desVar(   "C1" 4.2000000000000003e-13 )
desVar(   "C2" 5e-13 )
desVar(   "Ld" 3.74e-09 )
desVar(   "Lg" 9.4e-09 )
desVar(   "Ls" 6e-10 )
desVar(	  "R1" 1.5k	)
desVar(	  "R2" 2.5k	)
desVar(	  "R3" 400	)
desVar(	  "VDD" 2.5	)
desVar(	  "W" 1.5u	)
desVar(   "WN1" 5.5e-06 )
desVar(   "WN2" 5.1e-06 )
envOption(
	'analysisOrder  list("dc" "sp")
)
saveOption( 'pwr "all" )
saveOption( 'save "all" )
temp( 27 )
run()

S11Min = ymin(db(spm('sp 1 1)))
GTMax = ymax(db10(gt(sp(1 1 ?result "sp") sp(1 2 ?result "sp") sp(2 1 ?result "sp") sp(2 2 ?result "sp"))))
NFMin = (ymin(db10(getData("F" ?result "sp_noise"))) + 1)
Bandwidth = (xmax(cross(db10(gt(sp(1 1 ?result "sp") sp(1 2 ?result "sp") sp(2 1 ?result "sp") sp(2 2 ?result "sp"))) (ymax(db10(gt(sp(1 1 ?result "sp") sp(1 2 ?result "sp") sp(2 1 ?result "sp") sp(2 2 ?result "sp")))) - 3) 2 "either" t "time" nil) 1) - xmin(cross(db10(gt(sp(1 1 ?result "sp") sp(1 2 ?result "sp") sp(2 1 ?result "sp") sp(2 2 ?result "sp"))) (ymax(db10(gt(sp(1 1 ?result "sp") sp(1 2 ?result "sp") sp(2 1 ?result "sp") sp(2 2 ?result "sp")))) - 3) 2 "either" t "time" nil) 1))
PowerConsumption = getData(":pwr" ?result "dcOp")

filePtr = outfile("./results.txt" "w")
ocnPrint( ?output filePtr "Simulated performance ..." )
ocnPrint( ?output filePtr ?numberNotation 'scientific ?numSpaces 1 "S11Min:" S11Min )
ocnPrint( ?output filePtr ?numberNotation 'scientific ?numSpaces 1 "GTMax:" GTMax )
ocnPrint( ?output filePtr ?numberNotation 'scientific ?numSpaces 1 "NFMin:" NFMin )
ocnPrint( ?output filePtr ?numberNotation 'scientific ?numSpaces 1 "Bandwidth:" Bandwidth )
ocnPrint( ?output filePtr ?numberNotation 'scientific ?numSpaces 1 "PowerConsumption:" PowerConsumption )
close(filePtr)
