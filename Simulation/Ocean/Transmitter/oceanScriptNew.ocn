simulator( 'spectre )
design(	 "/home/julien/Shared/Projects/simulation/VCO_PA/spectre/schematic/netlist/netlist")
resultsDir( "/home/julien/Shared/Projects/simulation/VCO_PA/spectre/schematic" )
modelFile(
    '("/opt/cadence/installs/ncsu-cdk-1.6.0/models/45n270AModels.sp" "")
)
analysis('sp ?ports list("/PORT0" "/PORT1")  ?start "1G"  ?stop "50G"  )
analysis('pnoise ?sweeptype "relative"  ?relharmnum "1"  ?start "10k"
		?stop "10M"  ?p "/VCO_OUT+"  ?n "/VCO_OUT-"  ?oprobe ""
		?noiseout list("pm")  ?noisetypeUI ""  ?noiseoutUI "PM"  ?ppv ""  )
analysis('tran ?stop "10n"  ?triseTemp "1.0"  )
analysis('dc ?saveOppoint t  )
analysis('pss ?engine "Harmonic Balance"  ?flexbalance "yes"  ?oversamplefactor ""
		?fund "28G"  ?harms "10"  ?errpreset "moderate"  ?tstabenvlp_autosteady ""
		?tstabenvlpstop ""  ?oscana t  ?p "/VCO_OUT+"  ?n "/VCO_OUT-"
		?oscic "lin"  ?oscmethod ""  ?param "Vcont"  ?start "0"
		?stop "1.2"  ?sweepStep "0.1"  ?step ""  ?writefinal ""
		?swapfile ""  ?checkpss ""  ?ppv ""  ?backtracking ""  )
desVar(   "C1_VCO" 1.5e-13 )
desVar(   "L1_VCO" 1.8e-10 )
desVar(   "Rp_VCO" 380.0 )
desVar(	  "Wn5_VCO" 6u	)
desVar(   "Wn6_VCO" 7.8e-06 )
desVar(   "Wn_VCO" 2.5e-06 )
desVar(   "Wvar_VCO" 4.5e-06 )
desVar(	  "C1" 100f	)
desVar(	  "Cmatch1" 500f	)
desVar(	  "Cmatch2" 96f	)
desVar(	  "Iref" 500u	)
desVar(	  "L1" 120p	)
desVar(   "L1p_PA" 3.5e-10 )
desVar(   "L1s_PA" 1.2e-10 )
desVar(	  "L2p_PA" 460p	)
desVar(	  "L2s_PA" 310p	)
desVar(   "L3p_PA" 7.129999999999999e-10 )
desVar(   "L3s_PA" 4.5e-11 )
desVar(	  "Lm_PA" 87.5p	)
desVar(	  "Lmatch1" 4n	)
desVar(	  "Lmatch2" 104p	)
desVar(	  "Rp" 400	)
desVar(	  "Vb1" 1.2	)
desVar(	  "Vb2" 1.2	)
desVar(	  "Vcont" 600m	)
desVar(	  "Vinb1" 850m	)
desVar(	  "Vinb2" 850m	)
desVar(	  "Wbias" 5u	)
desVar(	  "Wbuffer" 8u	)
desVar(	  "Wn" 2u	)
desVar(   "Wn1_PA" 3.2e-05 )
desVar(   "Wn2_PA" 2.6e-05 )
desVar(	  "Wn5" 6u	)
desVar(	  "Wn6" 8u	)
desVar(	  "Wvar" 4u	)
desVar(	  "fin" 28G	)
desVar(	  "q" 30	)
envOption(
	'analysisOrder  list("dc" "tran" "pss" "pnoise" "sp")
)
saveOption( 'pwr "all" )
saveOption( 'save "all" )
save( 'v "/OUT" "/net7" "/net4" "/VCO_OUT+" "/VCO_OUT-" "/net8" )
save( 'i "/V1/PLUS" "/I19/Vout+" "/I19/Vin+" )
converge( 'ic "/I18/out+" "0" )
converge( 'ic "/I18/out-" "1.2" )
temp( 27 )
run()

dcPowerConsumption = getData(":pwr" ?result "dcOp")
Bandwidth = (ymax(cross(db10(gt(sp(1 1 ?result "sp") sp(1 2 ?result "sp") sp(2 1 ?result "sp") sp(2 2 ?result "sp"))) (ymax(db10(gt(sp(1 1 ?result "sp") sp(1 2 ?result "sp") sp(2 1 ?result "sp") sp(2 2 ?result "sp")))) - 3) 2 "either" t "time" nil)) - ymin(cross(db10(gt(sp(1 1 ?result "sp") sp(1 2 ?result "sp") sp(2 1 ?result "sp") sp(2 2 ?result "sp"))) (ymax(db10(gt(sp(1 1 ?result "sp") sp(1 2 ?result "sp") sp(2 1 ?result "sp") sp(2 2 ?result "sp")))) - 3) 2 "either" t "time" nil)))
OutputPower = ymax(dbm(pvr('pss "/OUT" "/gnd!" 50.0 '(1))))
VoltageSwing = (ymax(v("/OUT" ?result "tran")) - ymin(v("/OUT" ?result "tran")))
TuningRange_VCO = (ymax(harmonic(xval(getData("/VCO_OUT+" ?result "pss_fd")) '1)) - ymin(harmonic(xval(getData("/VCO_OUT+" ?result "pss_fd")) '1)))
PhaseNoise_VCO = value(leafValue(pn('pnoise) "Vcont" 0.6) 1000000)
LargeSignal_PowerGain_PA = ymax(db10((pvi('pss "/net7" "/net4" "/I19/Vout+" 0 '(1)) / (- pvi('pss "/VCO_OUT+" "/VCO_OUT-" "/I19/Vin+" 0 '1)))))
DrainEfficiency_PA = ymax(((- (pvi('pss "/net7" "/net4" "/I19/Vout+" 0 '(1)) / (- pvi('pss "/net8" "/gnd!" "/V1/PLUS" 0 '0)))) * 100))
PAE_PA = ymax((- ((100.0 * harmonic((spectralPower(i("/I19/Vout+" ?result "pss_fd") (v("/net7" ?result "pss_fd") - v("/net4" ?result "pss_fd"))) + spectralPower(i("/I19/Vin+" ?result "pss_fd") (v("/VCO_OUT+" ?result "pss_fd") - v("/VCO_OUT-" ?result "pss_fd")))) '(1))) / (- harmonic(spectralPower(i("/V1/PLUS" ?result "pss_fd") (v("/net8" ?result "pss_fd") - 0.0)) '(0))))))

filePtr = outfile("./results.txt" "w")
ocnPrint( ?output filePtr "Simulated performance ..." )
ocnPrint( ?output filePtr ?numberNotation 'scientific ?numSpaces 1 "PowerConsumption:" dcPowerConsumption )
ocnPrint( ?output filePtr ?numberNotation 'scientific ?numSpaces 1 "Bandwidth:" Bandwidth )
ocnPrint( ?output filePtr ?numberNotation 'scientific ?numSpaces 1 "OutputPower:" OutputPower )
ocnPrint( ?output filePtr ?numberNotation 'scientific ?numSpaces 1 "VoltageSwing:" VoltageSwing )
ocnPrint( ?output filePtr ?numberNotation 'scientific ?numSpaces 1 "TuningRange_VCO:" TuningRange_VCO )
ocnPrint( ?output filePtr ?numberNotation 'scientific ?numSpaces 1 "PhaseNoise_VCO:" PhaseNoise_VCO )
ocnPrint( ?output filePtr ?numberNotation 'scientific ?numSpaces 1 "LargeSignal_PowerGain_PA:" LargeSignal_PowerGain_PA )
ocnPrint( ?output filePtr ?numberNotation 'scientific ?numSpaces 1 "DrainEfficiency_PA:" DrainEfficiency_PA )
ocnPrint( ?output filePtr ?numberNotation 'scientific ?numSpaces 1 "PAE_PA:" PAE_PA )
close(filePtr)
