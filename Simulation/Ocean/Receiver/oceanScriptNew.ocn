simulator( 'spectre )
design(	 "/home/julien/Shared/Projects/simulation/Receiver_System_CombinationPerformance/spectre/schematic/netlist/netlist")
resultsDir( "/home/julien/Shared/Projects/simulation/Receiver_System_CombinationPerformance/spectre/schematic" )
modelFile(
    '("/opt/cadence/installs/ncsu-cdk-1.6.0/models/45n270AModels.sp" "")
)
analysis('pss ?engine "Harmonic Balance"  ?flexbalance "yes"  ?oversamplefactor ""
		?fund "27.9G"  ?harms "10"  ?errpreset "moderate"  ?tstabenvlpstopHB ""
		?step ""  ?writefinal ""  ?swapfile ""  ?checkpss ""
		?backtracking ""  )
analysis('psp ?start "1"  ?stop "100M"  ?portharmsvec list("1" "0" "1")
		?ports "[/PORT0 /PORT1 /PORT2]"  ?maxsideband "10"  ?relativeTol ""  )
analysis('pac ?outType "Voltage"  ?start "27.9G"  ?stop "28G"
		?maxsideband "2"  ?relativeTol ""  )
analysis('dc ?saveOppoint t  )
desVar(   "C1_LNA" 1.3e-13 )
desVar(   "C2_LNA" 2.1999999999999997e-13 )
desVar(   "C_Mixer" 1.081e-12 )
desVar(	  "Cf" 15p	)
desVar(	  "Cmatch" 100f	)
desVar(	  "Cmatch2" 1p	)
desVar(	  "Cmatch_lna" 200f	)
desVar(	  "Ibias_Amp" 2m	)
desVar(	  "Itail_Mixer" 2.5m	)
desVar(   "Ld_LNA" 2.3000000000000003e-10 )
desVar(   "Lg_LNA" 8.5e-10 )
desVar(	  "Lmatch" 260p	)
desVar(	  "Lmatch2" 50n	)
desVar(	  "Lmatch_lna" 350p	)
desVar(   "Ls_LNA" 8e-11 )
desVar(	  "R1_LNA" 160	)
desVar(	  "R2_LNA" 1.3k	)
desVar(	  "R3_LNA" 1.5k	)
desVar(   "R_Mixer" 500.0 )
desVar(   "Rd_Amp" 400.0 )
desVar(	  "Rf" 100	)
desVar(	  "VDD" 1.2	)
desVar(   "WLO_Mixer" 4.94e-06 )
desVar(   "WN1_LNA" 4.6e-06 )
desVar(   "WN2_LNA" 8.01e-06 )
desVar(   "WRF_Mixer" 9e-06 )
desVar(	  "W_LNA" 2.5u	)
desVar(   "Wn1_Amp" 6.634999999999999e-06 )
desVar(   "Wn2_Amp" 3.96e-06 )
desVar(	  "flo" 27.9G	)
desVar(	  "pacmag" 1	)
desVar(	  "plo" 10	)
envOption(
	'analysisOrder  list("dc" "tran" "pss" "pac" "psp")
)
saveOption( 'pwr "all" )
saveOption( 'save "all" )
temp( 27 )
run()

PowerConsumption = getData(":pwr" ?result "dcOp")
VoltageGain = ymax(db(vh('pac "/IF_OUT" '-1)))
NoiseFigure = ymin(getData("NF" ?result "psp"))

filePtr = outfile("./results.txt" "w")
ocnPrint( ?output filePtr "Simulated performance ..." )
ocnPrint( ?output filePtr ?numberNotation 'scientific ?numSpaces 1 "PowerConsumption:" PowerConsumption )
ocnPrint( ?output filePtr ?numberNotation 'scientific ?numSpaces 1 "VoltageGain:" VoltageGain)
ocnPrint( ?output filePtr ?numberNotation 'scientific ?numSpaces 1 "NoiseFigure:" NoiseFigure)
close(filePtr)
