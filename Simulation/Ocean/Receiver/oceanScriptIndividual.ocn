simulator( 'spectre )
design(	 "/home/julien/simulation/Receiver_System_IndividualMetrics/spectre/schematic/netlist/netlist")
resultsDir( "/home/julien/simulation/Receiver_System_IndividualMetrics/spectre/schematic" )
modelFile(
    '("/opt/cadence/installs/ncsu-cdk-1.6.0/models/45n270AModels.sp" "")
)
analysis('qpss ?funds list("LO" "RF")  ?maxharms list("1" "1")  ?errpreset "conservative"  )
analysis('sp ?ports list("/PORT0" "/PORT3")  ?start "1G"  ?stop "50G"
		?donoise "yes"  ?oprobe "/PORT3"  ?iprobe "/PORT0"  )
analysis('tran ?stop "10n"  ?triseTemp "1.0"  )
analysis('dc ?saveOppoint t  )
desVar(	  "C1_LNA" 130f	)
desVar(	  "C2_LNA" 170f	)
desVar(	  "C_Mixer" 1p	)
desVar(	  "Cf" 15p	)
desVar(	  "Cmatch" 100f	)
desVar(	  "Cmatch2" 1p	)
desVar(	  "Cmatch_lna" 200f	)
desVar(	  "Ibias_Amp" 2m	)
desVar(	  "Itail_Mixer" 2.5m	)
desVar(	  "Ld_LNA" 180p	)
desVar(	  "Lg_LNA" 850p	)
desVar(	  "Lmatch" 260p	)
desVar(	  "Lmatch2" 50n	)
desVar(	  "Lmatch_lna" 350p	)
desVar(	  "Ls_LNA" 80p	)
desVar(	  "R1_LNA" 160	)
desVar(	  "R2_LNA" 1.3k	)
desVar(	  "R3_LNA" 1.5k	)
desVar(	  "R_Mixer" 400	)
desVar(	  "Rd_Amp" 300	)
desVar(	  "Rf" 100	)
desVar(	  "VDD" 1.2	)
desVar(	  "WLO_Mixer" 4u	)
desVar(	  "WN1_LNA" 4.6u	)
desVar(	  "WN2_LNA" 8u	)
desVar(	  "WRF_Mixer" 8u	)
desVar(	  "W_LNA" 2.5u	)
desVar(	  "Wn1_Amp" 7u	)
desVar(	  "Wn2_Amp" 4u	)
desVar(	  "fin" 28G	)
desVar(	  "flo" 27.9G	)
desVar(	  "pacmag" 1	)
desVar(	  "pin" -20	)
desVar(	  "plo" 10	)
envOption(
	'analysisOrder  list("dc" "tran" "sp" "qpss")
)
saveOption( 'pwr "all" )
saveOption( 'save "all" )
save( 'v "/Mixer_OUT+" "/Mixer_OUT-" )
save( 'i "/I0/Vin+" "/I0/Vin-" "/I0/Vout-" "/I0/Vout+" "/I1/RF+" "/I1/RF-" "/I1/IF+" "/I1/IF-" )
temp( 27 )
run()

PowerGain_LNA = ymax(db10((pvi('qpss "/LNA_OUT+" "/LNA_OUT-" "/I0/Vout+" 0) / (- pvi('qpss "/LNA_IN+" "/LNA_IN-" "/I0/Vin+" 0 '(0 1))))))
NoiseFigure_LNA = ymin(db10(getData("F" ?result "sp_noise")))
S11_LNA = ymin(db(spm('sp 1 1)))
dcPowerConsumption_LNA = getData("I0:pwr" ?result "dcOp")
ConversionGain_Mixer = ymax(db10((pvi('qpss "/Mixer_OUT+" "/Mixer_OUT-" "/I1/IF+" 0) / (- pvi('qpss "/Mixer_IN+" "/Mixer_IN-" "/I1/RF+" 0 '(0 1))))))
VoltageSwing_Mixer = ((ymax((vtime('tran "/Mixer_OUT+") - vtime('tran "/Mixer_OUT-") - (v("/Mixer_OUT+" ?result "dcOp") - v("/Mixer_OUT-" ?result "dcOp")))) - ymin((vtime('tran "/Mixer_OUT+") - vtime('tran "/Mixer_OUT-") - (v("/Mixer_OUT+" ?result "dcOp") - v("/Mixer_OUT-" ?result "dcOp"))))) / 2)
dcPowerConsumption_Mixer = getData("I1:pwr" ?result "dcOp")
VoltageGain_Amp = ymax(db((vh('qpss "/Amp_OUT+") / harmonic(vh('qpss "/Amp_IN+") '((-1 1))))))
dcPowerConsumption_Amp = getData("I2:pwr" ?result "dcOp")

filePtr = outfile("./results.txt" "w")
ocnPrint( ?output filePtr "Simulated performance ..." )
ocnPrint( ?output filePtr ?numberNotation 'scientific ?numSpaces 1 "PowerGain_LNA:" PowerGain_LNA )
ocnPrint( ?output filePtr ?numberNotation 'scientific ?numSpaces 1 "NoiseFigure_LNA:" NoiseFigure_LNA )
ocnPrint( ?output filePtr ?numberNotation 'scientific ?numSpaces 1 "S11_LNA:" S11_LNA )
ocnPrint( ?output filePtr ?numberNotation 'scientific ?numSpaces 1 "ConversionGain_Mixer:" ConversionGain_Mixer )
ocnPrint( ?output filePtr ?numberNotation 'scientific ?numSpaces 1 "VoltageSwing_Mixer:" VoltageSwing_Mixer )
ocnPrint( ?output filePtr ?numberNotation 'scientific ?numSpaces 1 "VoltageGain_Amp:" VoltageGain_Amp )
close(filePtr)
