simulator( 'spectre )
design(	 "/home/julien/simulation/Mixer_testbench/spectre/schematic/netlist/netlist")
resultsDir( "/home/julien/simulation/Mixer_testbench/spectre/schematic" )
modelFile(
    '("/opt/cadence/installs/ncsu-cdk-1.6.0/models/45n270AModels.sp" "")
)
analysis('tran ?stop "20n"  ?triseTemp "1.0"  )
analysis('dc ?saveOppoint t  )
desVar(	  "Itail" 2m	)
desVar(   "C" 6.4e-13 )
desVar(	  "flo" 5.5G	)
desVar(	  "frf" 5.6G	)
desVar(	  "pacmag" 1	)
desVar(	  "plo" 10	)
desVar(	  "prf" -40	)
desVar(   "R" 325.0 )
desVar(   "WLO" 1.42e-05 )
desVar(	  "WRF" 20u	)
envOption(
	'analysisOrder  list("dc" "tran")
)
saveOption( 'pwr "all" )
saveOption( 'save "all" )
temp( 27 )
run()
selectResult( 'dcOp )
selectResult( 'tran )
IFVoltageSwing = (peakToPeak(v("/IF_out" ?result "tran")) / 2)

filePtr = outfile("./results.txt" "w")
ocnPrint( ?output filePtr "Simulated performance ..." )
ocnPrint( ?output filePtr ?numberNotation 'scientific ?numSpaces 1 "IFVoltageSwing:" IFVoltageSwing)
close(filePtr)
