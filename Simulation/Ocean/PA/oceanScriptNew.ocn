simulator( 'spectre )
design(  "/home/julien/Shared/Projects/simulation/PA_testbench/spectre/schematic/netlist/netlist")
resultsDir( "/home/julien/Shared/Projects/simulation/PA_testbench/spectre/schematic" )
modelFile(
    '("/opt/cadence/installs/ncsu-cdk-1.6.0/models/45n270AModels.sp" "")
)
analysis('sp ?ports list("/PORT0" "/PORT1")  ?start "0"  ?stop "50G"
		?step "0.5G"  )
analysis('tran ?stop "20n"  ?triseTemp "1.0"  )
analysis('pac ?outType "Voltage"  ?start "28.02G"  ?stop ""
		?relativeTol ""  )
analysis('dc ?saveOppoint t  )
analysis('pss ?engine "Harmonic Balance"  ?flexbalance "yes"  ?oversamplefactor "1"
		?fund "28G"  ?harms "20"  ?errpreset "moderate"  ?tstabenvlpstopHB ""
		?param "pin"  ?start "-30"  ?stop "10"  ?sweepStep "1"
		?step ""  ?writefinal ""  ?swapfile ""  ?checkpss ""
		?backtracking ""  )
desVar(	  "fin" 28G	)
desVar(	  "pin" -20	)
desVar(   "L1p" 3.15e-10 )
desVar(   "L1s" 8e-11 )
desVar(	  "L2p" 460p	)
desVar(	  "L2s" 310p	)
desVar(   "L3p" 2.3800000000000006e-10 )
desVar(   "L3s" 3e-11 )
desVar(   "Lm" 1.927e-10 )
desVar(	  "q" 30	)
desVar(	  "Vb1" 1.2	)
desVar(	  "Vb2" 1.2	)
desVar(	  "Vinb1" 0.8	)
desVar(	  "Vinb2" 750m	)
desVar(   "Wn1" 1.9e-05 )
desVar(   "Wn2" 3.6e-05 )
envOption(
	'analysisOrder  list("dc" "tran" "sp" "pss" "pac")
)
saveOption( 'pwr "all" )
saveOption( 'save "all" )
save( 'v "/net6" "/net5" "/VDD" )
save( 'i "/PORT0/PLUS" "/V1/PLUS" )
temp( 27 )
run()

S11 = value(db(spm('sp 1 1)) 2.8e+10)
S22 = value(db(spm('sp 2 2)) 2.8e+10)
LargeSignalPowerGain = value(db10((value(pvr('pss "/net6" "/gnd!" 50.0) 'pin -20) / value((- pvi('pss "/net5" "/gnd!" "/PORT0/PLUS" 0 '1)) 'pin -20))) 2.8e+10)
PAE = ymax(((100.0 * harmonic((let(((vn (v("/net6" ?result "pss_fd") - 0.0))) spectralPower((vn / resultParam("PORT1:r" ?result "pss_fd")) vn)) + spectralPower(i("/PORT0/PLUS" ?result "pss_fd") (v("/net5" ?result "pss_fd") - 0.0))) '(1))) / (- harmonic(spectralPower(i("/V1/PLUS" ?result "pss_fd") (v("/VDD" ?result "pss_fd") - 0.0)) '(0)))))
DrainEfficiency = (100 * ymax((pvi('pss "/gnd!" "/net6" "/PORT1/MINUS" 0 '(1)) / (- pvi('pss "/VDD" "/gnd!" "/V1/PLUS" 0 '0)))))
PSAT = ymax(compressionVRICurves((v("/net6" ?result "pss_fd") - 0.0) '1 ?rport resultParam("PORT1:r" ?result "pss_fd") ?gcomp 1))
PowerConsumption = getData(":pwr" ?result "dcOp")

filePtr = outfile("./results.txt" "w")
ocnPrint( ?output filePtr "Simulated performance ..." )
ocnPrint( ?output filePtr ?numberNotation 'scientific ?numSpaces 1 "S11:" S11 )
ocnPrint( ?output filePtr ?numberNotation 'scientific ?numSpaces 1 "S22:" S22 )
ocnPrint( ?output filePtr ?numberNotation 'scientific ?numSpaces 1 "LargeSignalPowerGain:" LargeSignalPowerGain )
ocnPrint( ?output filePtr ?numberNotation 'scientific ?numSpaces 1 "PAE:" PAE )
ocnPrint( ?output filePtr ?numberNotation 'scientific ?numSpaces 1 "DrainEfficiency:" DrainEfficiency )
ocnPrint( ?output filePtr ?numberNotation 'scientific ?numSpaces 1 "PSAT:" PSAT )
ocnPrint( ?output filePtr ?numberNotation 'scientific ?numSpaces 1 "PowerConsumption:" PowerConsumption )
close(filePtr)
