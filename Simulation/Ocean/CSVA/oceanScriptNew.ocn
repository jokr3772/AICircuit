simulator( 'spectre )
design(  "/home/julien/Shared/Projects/simulation/SingleStage/spectre/schematic/netlist/netlist")
resultsDir( "/home/julien/Shared/Projects/simulation/SingleStage/spectre/schematic" )
modelFile(
    '("/opt/cadence/installs/ncsu-cdk-1.6.0/models/45n270AModels.sp" "")
)
analysis('ac ?start "0"  ?stop "1G"  )
analysis('dc ?saveOppoint t  )
desVar(   "Rd" 860.0 )
desVar(   "VDD" 1.3800000000000001 )
desVar(   "Vgate" 0.61 )
desVar(   "Wn" 3.4000000000000005e-06 )
envOption(
	'analysisOrder  list("dc" "ac")
)
saveOption( 'pwr "all" )
saveOption( 'save "all" )
save( 'v "/Vout" "/Vin" )
temp( 27 )
run()

VoltageGain = ymax(dB20((VF("/Vout") / VF("/Vin"))))
Bandwidth = bandwidth((VF("/Vout") / VF("/Vin")) 3 "low")
PowerConsumption = getData(":pwr" ?result "dcOp")

filePtr = outfile("./results.txt" "w")
ocnPrint( ?output filePtr "Simulated performance ..." )
ocnPrint( ?output filePtr ?numberNotation 'scientific ?numSpaces 1 "VoltageGain:" VoltageGain )
ocnPrint( ?output filePtr ?numberNotation 'scientific ?numSpaces 1 "Bandwidth:" Bandwidth )
ocnPrint( ?output filePtr ?numberNotation 'scientific ?numSpaces 1 "PowerConsumption:" PowerConsumption )
close(filePtr)
